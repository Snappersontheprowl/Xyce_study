* FV-007: resistor noise smoke test
V1 in 0 DC 0 AC 1
R1 in out 1k
R2 out 0 1k
.NOISE V(out) V1 DEC 10 1 1MEG
.PRINT NOISE ONOISE INOISE
.END
