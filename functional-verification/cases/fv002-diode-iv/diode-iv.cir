* FV-002: diode IV smoke test
V1 anode 0 0
D1 anode 0 DMOD
.MODEL DMOD D(IS=1e-14 N=1)
.DC V1 0 0.8 0.01
.PRINT DC V(anode) I(V1)
.END
